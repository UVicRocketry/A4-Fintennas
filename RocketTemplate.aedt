# Ansys Electronics Desktop project, version 2025.2
materials:
  vacuum: permittivity=1
  aluminum: permeability=1.000021 conductivity=38000000
  FR4_epoxy: permittivity=4.4 dielectric_loss_tangent=0.02
  air: permittivity=1.0006 permeability=1.0000004
  quartz_glass: permittivity=3.78
  cyanate_ester: permittivity=3.8

design HFSSDesign1 (HFSS, HFSS Terminal Network, model units mm)
variables:
  fuselageOD = 152.4mm
  fuselageLength = 254mm
  fuselageWallThickness = 6.35mm
  finLength = 203.2mm
  substrateHeight = 0.8mm
  finWidth = 25.4mm
  tabLength = 10mm
  epoxyThickness = 3.175mm
  copperThickness = 0.035mm
geometry:
  fuselage [aluminum] = cylinder(axis=Y, base_centre=(-fuselageOD/2, -fuselageLength/2, 0mm), radius=fuselageOD/2, height=fuselageLength, segments=200)
  fuselageInner = cylinder(axis=Y, base_centre=(-fuselageOD/2, -fuselageLength/2, 0mm), radius=fuselageOD/2-fuselageWallThickness, height=fuselageLength, segments=200)
  fuselage.subtract(fuselageInner)
  FinPCB [FR4_epoxy] = box(corner=(0mm, -finLength/2, -substrateHeight/2), size=(finWidth, finLength, substrateHeight))
  radBoundary [air] = box(corner=(-fuselageOD/4, -(fuselageLength+30mm)/2, -fuselageOD/2), size=(110mm, fuselageLength+30mm, fuselageOD))
  radBoundary1 = box(corner=(-fuselageOD/4, -(fuselageLength+30mm)/2, -fuselageOD/2), size=(110mm, fuselageLength+30mm, fuselageOD))
  fuselage.intersect(radBoundary1)
  PCBTabUpper = box(corner=(-(fuselageWallThickness+5mm), finLength/2, -substrateHeight/2), size=(fuselageWallThickness+5mm, -tabLength, substrateHeight))
  FinOuterMold [cyanate_ester] = box(corner=(0mm, -(finLength+2*epoxyThickness)/2, -(substrateHeight+2*copperThickness+2*epoxyThickness)/2), size=(finWidth+epoxyThickness, finLength+2*epoxyThickness, substrateHeight+2*copperThickness+2*epoxyThickness))
  FinPCB1 = box(corner=(0mm, -finLength/2, -(substrateHeight+2*copperThickness)/2), size=(finWidth, finLength, substrateHeight+2*copperThickness))
  FinOuterMold.subtract(FinPCB1)
  ExpoxyTab = box(corner=(-(fuselageWallThickness+5mm), finLength/2+epoxyThickness, -(substrateHeight+2*copperThickness+2*epoxyThickness)/2), size=(fuselageWallThickness+5mm, -tabLength-2*epoxyThickness, substrateHeight+2*copperThickness+2*epoxyThickness))
  PCBTabUpper1 = box(corner=(-(fuselageWallThickness+5mm), finLength/2, -(substrateHeight+2*copperThickness)/2), size=(fuselageWallThickness+5mm, -tabLength, substrateHeight+2*copperThickness))
  ExpoxyTab.subtract(PCBTabUpper1)
  PCBTabUpper2 = box(corner=(-(fuselageWallThickness+5mm), finLength/2, -substrateHeight/2), size=(fuselageWallThickness+5mm, -tabLength, substrateHeight))
  ExpoxyTab1 = box(corner=(-(fuselageWallThickness+5mm), finLength/2+epoxyThickness, -(substrateHeight+2*copperThickness+2*epoxyThickness)/2), size=(fuselageWallThickness+5mm, -tabLength-2*epoxyThickness, substrateHeight+2*copperThickness+2*epoxyThickness))
  PCBTabUpper3 = box(corner=(-(fuselageWallThickness+5mm), finLength/2, -(substrateHeight+2*copperThickness)/2), size=(fuselageWallThickness+5mm, -tabLength, substrateHeight+2*copperThickness))
  ExpoxyTab1.subtract(PCBTabUpper3)
  [PCBTabUpper2, ExpoxyTab1].rotate(axis=X, angle=180deg)
  FinPCB.unite(PCBTabUpper, PCBTabUpper2)
  FinOuterMold.chamfer(Edges=FinOuterMold.edge(at (14.2875, 104.775, 3.61), at (28.575, 0, 3.61), at (14.2875, 104.775, -3.61), at (28.575, 0, -3.61), at (14.2875, -104.775, -3.61), at (14.2875, -104.775, 3.61)) LeftDistance=(substrateHeight+2*copperThickness+2*epoxyThickness)/2 RightDistance=7mm ChamferType="Left Distance-Right Distance" ChamferAdditionalGeometryInfo{ChamferEdgeGeometryInfo{ChamferEdgeID=3816 ChamferEdgeSense ChamferEdgeStart{X=28.575mm Y=-104.775mm Z=3.61mm} ChamferEdgeEnd{X=0mm Y=-104.775mm Z=3.61mm} ChamferEdgeMid{X=14.2875mm Y=-104.775mm Z=3.61mm} ChamferEdgeMidTangent(-1, 0, 0)} ChamferEdgeGeometryInfo{ChamferEdgeID=3814 ChamferEdgeSense ChamferEdgeStart{X=0mm Y=104.775mm Z=3.61mm} ChamferEdgeEnd{X=28.575mm Y=104.775mm Z=3.61mm} ChamferEdgeMid{X=14.2875mm Y=104.775mm Z=3.61mm} ChamferEdgeMidTangent(1, 0, 0)} ChamferEdgeGeometryInfo{ChamferEdgeID=3813 ChamferEdgeSense ChamferEdgeStart{X=28.575mm Y=104.775mm Z=3.61mm} ChamferEdgeEnd{X=28.575mm Y=-104.775mm Z=3.61mm} ChamferEdgeMid{X=28.575mm Y=0mm Z=3.61mm} ChamferEdgeMidTangent(0, -1, 0)} ChamferEdgeGeometryInfo{ChamferEdgeID=3817 ChamferEdgeSense ChamferEdgeStart{X=28.575mm Y=-104.775mm Z=-3.61mm} ChamferEdgeEnd{X=28.575mm Y=104.775mm Z=-3.61mm} ChamferEdgeMid{X=28.575mm Y=0mm Z=-3.61mm} ChamferEdgeMidTangent(0, 1, 0)} ChamferEdgeGeometryInfo{ChamferEdgeID=3820 ChamferEdgeSense ChamferEdgeStart{X=28.575mm Y=104.775mm Z=-3.61mm} ChamferEdgeEnd{X=0mm Y=104.775mm Z=-3.61mm} ChamferEdgeMid{X=14.2875mm Y=104.775mm Z=-3.61mm} ChamferEdgeMidTangent(-1, 0, 0)} ChamferEdgeGeometryInfo{ChamferEdgeID=3818 ChamferEdgeSense ChamferEdgeStart{X=0mm Y=-104.775mm Z=-3.61mm} ChamferEdgeEnd{X=28.575mm Y=-104.775mm Z=-3.61mm} ChamferEdgeMid{X=14.2875mm Y=-104.775mm Z=-3.61mm} ChamferEdgeMidTangent(1, 0, 0)}})
  ExpoxyTab2 = box(corner=(-(fuselageWallThickness+5mm), finLength/2+epoxyThickness, -(substrateHeight+2*copperThickness+2*epoxyThickness)/2), size=(fuselageWallThickness+5mm, -tabLength-2*epoxyThickness, substrateHeight+2*copperThickness+2*epoxyThickness))
  PCBTabUpper4 = box(corner=(-(fuselageWallThickness+5mm), finLength/2, -(substrateHeight+2*copperThickness)/2), size=(fuselageWallThickness+5mm, -tabLength, substrateHeight+2*copperThickness))
  ExpoxyTab2.subtract(PCBTabUpper4)
  ExpoxyTab3 = box(corner=(-(fuselageWallThickness+5mm), finLength/2+epoxyThickness, -(substrateHeight+2*copperThickness+2*epoxyThickness)/2), size=(fuselageWallThickness+5mm, -tabLength-2*epoxyThickness, substrateHeight+2*copperThickness+2*epoxyThickness))
  PCBTabUpper5 = box(corner=(-(fuselageWallThickness+5mm), finLength/2, -(substrateHeight+2*copperThickness)/2), size=(fuselageWallThickness+5mm, -tabLength, substrateHeight+2*copperThickness))
  ExpoxyTab3.subtract(PCBTabUpper5)
  ExpoxyTab3.rotate(axis=X, angle=180deg)
  fuselage.subtract(ExpoxyTab2, ExpoxyTab3)
  FinOuterMold.unite(ExpoxyTab, ExpoxyTab1)
boundaries and excitations:
  Rad1: Radiation Objects=radBoundary
